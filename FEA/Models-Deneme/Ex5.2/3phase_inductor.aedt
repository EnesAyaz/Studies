# Ansys Electronics Desktop project, version 2019.3
materials:
  vacuum: permittivity=1
  steel_1008: permeability{HUnit=A_per_meter BUnit=tesla curve (0, 0) (159.2, 0.2402) (318.3, 0.8654) (477.5, 1.1106) (636.6, 1.2458) (795.8, 1.331) (1591.5, 1.5) (3183.1, 1.6) (4774.6, 1.683) (6366.2, 1.741) (7957.7, 1.78) (15915.5, 1.905) (31831, 2.025) (47746.5, 2.085) (63662, 2.13) (79577.5, 2.165) (159155, 2.28) (318310, 2.485) (397887, 2.5851)} conductivity=2000000
  copper: permeability=0.999991 conductivity=58000000

design Maxwell3DDesign1 (Maxwell 3D, Magnetostatic, model units in)
variables:
  gap = 0.05in
  Mag = 30A
geometry:
  Core_E [steel_1008] = box(corner=(-1in, -6in, 0in), size=(2in, 12in, 10in))
  Box2 = box(corner=(-1in, 1in, 2in), size=(2in, 3in, 6in))
  Box2_1 = Box2.duplicate_around_axis(axis=Z, angle=180deg, total=2)
  Core_E.subtract(Box2, Box2_1)
  Box3 = box(corner=(-1in, -6in, 2in), size=(2in, 12in, gap))
  Core_E.subtract(Box3)
  Core_I [steel_1008] = Core_E.separate_bodies()
  Coil_Left [copper] = rectangle(corner=(0in, -3.6in, 3.5in), y_size=0.3in, z_size=-0.8in)
  Rectangle2 = rectangle(corner=(1.5in, -6.5in, 3in), x_size=-3in, y_size=3in, uncovered)
  Coil_Left.sweep_along_path(Rectangle2)
  Coil_Left_1, Coil_Left_2 [copper] = Coil_Left.duplicate_along_line(step=(0in, 0in, 1.925in), total=3)
  Coil_mid_1, Coil_right_1 [copper] = Coil_Left.duplicate_along_line(step=(0in, 5in, 0in), total=3)
  Coil_mid_2, Coil_right_2 [copper] = Coil_Left_1.duplicate_along_line(step=(0in, 5in, 0in), total=3)
  Coil_mid, Coil_right [copper] = Coil_Left_2.duplicate_along_line(step=(0in, 5in, 0in), total=3)
  Coil_Left_Section1 [copper] = Coil_Left.section(plane=YZ)
  Coil_Left_1_Section1 [copper] = Coil_Left_1.section(plane=YZ)
  Coil_Left_2_Section1 [copper] = Coil_Left_2.section(plane=YZ)
  Coil_mid_Section1 [copper] = Coil_mid.section(plane=YZ)
  Coil_mid_1_Section1 [copper] = Coil_mid_1.section(plane=YZ)
  Coil_mid_2_Section1 [copper] = Coil_mid_2.section(plane=YZ)
  Coil_right_Section1 [copper] = Coil_right.section(plane=YZ)
  Coil_right_1_Section1 [copper] = Coil_right_1.section(plane=YZ)
  Coil_right_2_Section1 [copper] = Coil_right_2.section(plane=YZ)
  Coil_mid_Section1.separate_bodies()
  Coil_right_1_Section1.separate_bodies()
  Coil_right_2_Section1.separate_bodies()
  Coil_mid_1_Section1.separate_bodies()
  Coil_mid_2_Section1.separate_bodies()
  Coil_right_Section1.separate_bodies()
  Coil_Left_Section1.separate_bodies()
  Coil_Left_1_Section1.separate_bodies()
  Coil_Left_2_Section1.separate_bodies()
  Region [vacuum] = region(percentage_offset: +X=400, -X=400, +Y=100, -Y=100, +Z=150, -Z=150)
boundaries and excitations:
  PhaseA_1: Current Objects=Coil_Left_Section1 Current=-0.5*Mag IsSolid=false Point_out_of_terminal=false
  PhaseA_2: Current Objects=Coil_Left_1_Section1 Current=-0.5*Mag IsSolid=false Point_out_of_terminal=false
  PhaseA_3: Current Objects=Coil_Left_2_Section1 Current=-0.5*Mag IsSolid=false Point_out_of_terminal=false
  PhaseB_1: Current Objects=Coil_mid_1_Section1 Current=Mag IsSolid=false Point_out_of_terminal=false
  PhaseB_2: Current Objects=Coil_mid_2_Section1 Current=Mag IsSolid=false Point_out_of_terminal=false
  PhaseB_3: Current Objects=Coil_mid_Section1 Current=Mag IsSolid=false Point_out_of_terminal=false
  PhaseC_1: Current Objects=Coil_right_1_Section1 Current=-0.5*Mag IsSolid=false Point_out_of_terminal=false
  PhaseC_2: Current Objects=Coil_right_2_Section1 Current=-0.5*Mag IsSolid=false Point_out_of_terminal=false
  PhaseC_3: Current Objects=Coil_right_Section1 Current=-0.5*Mag IsSolid=false Point_out_of_terminal=false
parameters:
  Matrix1: Matrix PhaseA_1, PhaseA_2, PhaseA_3, PhaseB_1, PhaseB_2, PhaseB_3, PhaseC_1, PhaseC_2, PhaseC_3: NumberOfTurns=1; group Group1 = PhaseA_1, PhaseA_2, PhaseA_3 (1 parallel); group Group2 = PhaseB_1, PhaseB_2, PhaseB_3 (1 parallel); group Group3 = PhaseC_1, PhaseC_2, PhaseC_3 (1 parallel)
mesh:
  initial mesh: GlobalCurvilinear{Apply}
setups:
  Setup1: Magnetostatic MaximumPasses=10 MinimumPasses=2 MinimumConvergedPasses=1 PercentRefinement=30 PercentError=1 NonLinearResidual=0.001
