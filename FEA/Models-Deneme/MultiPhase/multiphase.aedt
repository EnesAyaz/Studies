# Ansys Electronics Desktop project, version 2019.3
materials:
  vacuum: permittivity=1
  ferrite: permittivity=12 permeability=1000 conductivity=0.01
  copper: permeability=0.999991 conductivity=58000000

design Maxwell3DDesign1 (Maxwell 3D, Magnetostatic, model units mm)
variables:
  radius = 30mm
  height = 100mm
  center_x = 90mm
  radius_core = 30mm
  height_core = 100mm
  center_y = 90mm
  conductor_width = 20mm
  condcutor_width = 20mm
  airgap = 5mm
  litz_width = 5mm
  sweep_angle = 100deg
  inner_angle = 40deg
  currentA = 10A
  phaseB = 5A
  currentC = -5A
  currentB = -5A
geometry:
  core_A1 [ferrite] = cylinder(axis=Z, base_centre=(center_x, center_y, -height_core/2), radius=radius_core, height=height_core)
  phaseA1 [copper] = rectangle(corner=(center_x, center_y+radius_core+2mm, -height_core/4), y_size=condcutor_width, z_size=height_core/2)
  coordinate_system conductor = origin=(center_x, center_y, 0mm) x=(1mm, 0mm, 0mm) y=(0mm, 1mm, 0mm)
  phaseA1.sweep_around_axis(axis=Z, angle=360deg) in conductor
  coordinate_system secondary = origin=(0mm, 0mm, height/2+airgap) x=(1mm, 0mm, 0mm) y=(0mm, 1mm, 0mm)
  phaseA1_Section1 = phaseA1.section(plane=YZ) in conductor
  cross_section_A1 [copper] = phaseA1_Section1.separate_bodies()
  phaseA1_Section1.delete()
  phaseB2, phaseC1, phaseA2, phaseB1, phaseC2 [copper] = phaseA1.duplicate_around_axis(axis=Z, angle=60deg, total=6)
  core_B2, core_C1, core_A2, core_B1, core_C2 [ferrite] = core_A1.duplicate_around_axis(axis=Z, angle=60deg, total=6)
  cross_section_B2, cross_section_C1, cross_section_A2, cross_section_B1, cross_section_C2 [copper] = cross_section_A1.duplicate_around_axis(axis=Z, angle=60deg, total=6)
  Seconder_A [copper] = rectangle(corner=(0mm, center_y-radius_core, height_core/2+airgap), y_size=2*radius_core+2*condcutor_width, z_size=litz_width)
  inner_seconder = rectangle(corner=(0mm, center_y -radius_core+condcutor_width, height_core/2+airgap), y_size=2*radius_core, z_size=litz_width)
  inner_seconder.rotate(axis=Z, angle=inner_angle/2)
  Seconder_A.sweep_around_axis(axis=Z, angle=sweep_angle)
  inner_seconder.sweep_around_axis(axis=Z, angle=sweep_angle-inner_angle)
  Seconder_A.subtract(inner_seconder)
  coordinate_system secondary_surface = origin=(-50mm, 0mm, 0mm) x=(1mm, 0mm, 0mm) y=(0mm, 1mm, 0mm)
  cross_section_sec_A [copper] = Seconder_A.section(plane=YZ) in secondary_surface
  cross_section_sec_A.separate_bodies()
  Seconder_B, Seconder_C [copper] = Seconder_A.duplicate_around_axis(axis=Z, angle=90, total=3)
  cross_section_sec_B, cross_section_sec_C [copper] = cross_section_sec_A.duplicate_around_axis(axis=Z, angle=90, total=3)
  Region [vacuum] = region(percentage_offset=150 on all sides)
boundaries and excitations:
  CurrentA1: Current Objects=cross_section_A1 Current=currentA IsSolid=false Point_out_of_terminal=false
  CurrentB2: Current Objects=cross_section_B2 Current=-currentB IsSolid=false Point_out_of_terminal=false
  CurrentC1: Current Objects=cross_section_C1 Current=CurrentC IsSolid=false Point_out_of_terminal=false
  CurrentA2: Current Objects=cross_section_A2 Current=-currentA IsSolid=false Point_out_of_terminal=false
  CurrentB1: Current Objects=cross_section_B1 Current=currentB IsSolid=false Point_out_of_terminal=false
  CurrentC3: Current Objects=cross_section_C2 Current=-currentC IsSolid=false Point_out_of_terminal=false
  secA: Current Objects=cross_section_sec_A Current=currentA IsSolid=false Point_out_of_terminal=false
  secB: Current Objects=cross_section_sec_B Current=currentB IsSolid=false Point_out_of_terminal=false
  secC: Current Objects=cross_section_sec_C Current=currentC IsSolid=false Point_out_of_terminal=false
parameters:
  OneTurn: Matrix CurrentA1, CurrentA2, CurrentB1, CurrentB2, CurrentC1, CurrentC3, secA, secB, secC: NumberOfTurns=1; group Group1 = CurrentA1, CurrentA2 (1 parallel); group Group2 = CurrentB1, CurrentB2 (1 parallel); group Group3 = CurrentC1, CurrentC3 (1 parallel)
mesh:
  initial mesh: GlobalCurvilinear{Apply}
setups:
  Setup1: Magnetostatic MaximumPasses=10 MinimumPasses=2 MinimumConvergedPasses=1 PercentRefinement=30 PercentError=1 NonLinearResidual=0.001
