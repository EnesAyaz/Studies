# Ansys Electronics Desktop project, version 2020.2
materials:
  vacuum: permittivity=1
  copper: permeability=0.999991 conductivity=58000000
  ferrite: permittivity=12 permeability=1000 conductivity=0.01

design Only_primer (Maxwell 3D, Magnetostatic, model units mm)
variables:
  ferrite_distance = 2mm
  r_inner = r_inner_primer
  ch_primer = 2mm
  r_inner_primer = 25mm
  N_primer = 16
  ferrite_width = 5mm
  ferrite_height = 1mm
  ferrite_length = N_primer*ch_primer
  layer_distance = 4mm
  airgap = 20mm
geometry:
  coordinate_system ferrite_primer = origin=(0mm, 0mm, -ferrite_distance) x=(1mm, 0mm, 0mm) y=(0mm, 1mm, 0mm)
  Cylinder1 = cylinder(axis=Z, base_centre=(0mm, 0mm, 0mm), radius=r_inner_primer, height=ch_primer)
  primer_coil [copper] = cylinder(axis=Z, base_centre=(0mm, 0mm, 0mm), radius=r_inner_primer+N_primer*ch_primer, height=ch_primer)
  primer_coil.subtract(Cylinder1)
  Box1 [ferrite] = box(corner=(r_inner_primer, 0mm, 0mm), size=(ferrite_length, ferrite_width, -ferrite_height)) in ferrite_primer
  Box1_1..Box1_17 [ferrite] = Box1.duplicate_around_axis(axis=Z, angle=20deg, total=18) in ferrite_primer
  Region [vacuum] = region(absolute_offset=100mm on all sides) in ferrite_primer
  Circle1 = circle(normal=Z, centre=(0mm, 0mm, 10mm), radius=(r_inner+N_primer*ch_primer)*1.2)
  coordinate_system seconder_ferrite = origin=(0mm, 0mm, airgap) x=(1mm, 0mm, 0mm) y=(0mm, 1mm, 0mm)
  Box2 [ferrite] = box(corner=(r_inner_primer, 0mm, 0mm), size=(ferrite_length, ferrite_width, -ferrite_height)) in seconder_ferrite
  Box2_1..Box2_17 [ferrite] = Box2.duplicate_around_axis(axis=Z, angle=20deg, total=18) in ferrite_primer
  coordinate_system primer_2 = origin=(0mm, 0mm, layer_distance) x=(1mm, 0mm, 0mm) y=(0mm, 1mm, 0mm)
  primer_coil1 [copper] = cylinder(axis=Z, base_centre=(0mm, 0mm, 0mm), radius=r_inner_primer+N_primer*ch_primer, height=ch_primer) in primer_2
  Cylinder2 = cylinder(axis=Z, base_centre=(0mm, 0mm, 0mm), radius=r_inner_primer, height=ch_primer) in primer_2
  primer_coil1.subtract(Cylinder2)
  coordinate_system ferrite_primer1 = origin=(0mm, 0mm, -ferrite_distance) x=(1mm, 0mm, 0mm) y=(0mm, 1mm, 0mm)
  primer_coil_Section1 [copper] = primer_coil.section(plane=YZ)
  primer_coil1_Section1 [copper] = primer_coil1.section(plane=YZ)
  primer_coil_Section1.separate_bodies()
  primer_coil1_Section1.separate_bodies()
boundaries and excitations:
  Insulating1: Insulating Objects=primer_coil
  Current_1: Current Objects=primer_coil_Section1 Current=5A IsSolid=false Point_out_of_terminal=false
  Current_2: Current Objects=primer_coil1_Section1 Current=5A IsSolid=false Point_out_of_terminal=false
parameters:
  Matrix1: Matrix Current_1, Current_2: NumberOfTurns=N_primer
mesh:
  initial mesh: GlobalCurvilinear{Apply}
setups:
  Setup1: Magnetostatic MaximumPasses=10 MinimumPasses=2 MinimumConvergedPasses=1 PercentRefinement=30 PercentError=1 NonLinearResidual=0.001
