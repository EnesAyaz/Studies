# Ansys Electronics Desktop project, version 2019.3
materials:
  vacuum: permittivity=1
  Zirconium, pure, R60001: conductivity=2505400
  copper: permeability=0.999991 conductivity=58000000

design Maxwell3DDesign1 (Maxwell 3D, Magnetostatic, model units mm)
variables:
  r_inner = 40mm
  conductor_height = 2mm
  r_inner_middle = 70mm
  r_outer_middle = 90mm
  r_outer = 120mm
  airgap = 30mm
  angle_rotation = 60deg
geometry:
  coordinate_system primer = origin=(0mm, 0mm, 100mm) x=(1mm, 0mm, 0mm) y=(0mm, 1mm, 0mm)
  inner_cylinder = cylinder(axis=Z, base_centre=(0mm, 0mm, 0mm), radius=r_inner, height=conductor_height) in primer
  middle_inner_cylinder = cylinder(axis=Z, base_centre=(0mm, 0mm, 0mm), radius=r_inner_middle, height=conductor_height) in primer
  middle_inner_cylinder.subtract(inner_cylinder)
  middle_outer_cylinder = cylinder(axis=Z, base_centre=(0mm, 0mm, 0mm), radius=r_outer_middle, height=conductor_height) in primer
  outer_cylinder [copper] = cylinder(axis=Z, base_centre=(0mm, 0mm, 0mm), radius=r_outer, height=conductor_height) in primer
  outer_cylinder.subtract(middle_outer_cylinder)
  outer_cylinder_1 = outer_cylinder.duplicate_along_line(step=(0mm, 0mm, airgap), total=2) in primer
  middle_inner_cylinder_1 = middle_inner_cylinder.duplicate_along_line(step=(0mm, 0mm, airgap), total=2) in primer
  coordinate_system seconder = origin=(0mm, 0mm, airgap) x=(1mm, 0mm, 0mm) y=(0mm, 1mm, 0mm) in primer
  outer_cylinder_1_Split1 [copper] = outer_cylinder_1.split(plane=YZ, keep=Both) in seconder
  middle_inner_cylinder_1_Split1 = middle_inner_cylinder_1.split(plane=YZ, keep=Both) in seconder
  outer_cylinder_Split1 [copper] = outer_cylinder.split(plane=YZ, keep=Both) in primer
  middle_inner_cylinder_Split1 = middle_inner_cylinder.split(plane=YZ, keep=Both) in primer
  outer_cylinder_1_Split2 [copper] = outer_cylinder_1.split(plane=ZX, keep=Both) in seconder
  middle_inner_cylinder_1_Split2 = middle_inner_cylinder_1.split(plane=ZX, keep=Both) in seconder
  middle_inner_cylinder_1_Split1_Split1 [copper] = middle_inner_cylinder_1_Split1.split(plane=ZX, keep=Both) in seconder
  outer_cylinder_1_Split1_Split1 = outer_cylinder_1_Split1.split(plane=ZX, keep=Both) in seconder
  coordinate_system RelativeCS2 = origin=(0mm, r_inner_middle-r_inner+5mm, 0mm) x=(1mm, 0mm, 0mm) y=(0mm, 1mm, 0mm) in seconder
  Box1 = box(corner=(0mm, -r_outer, 0mm), size=(r_inner_middle-r_inner, 2*r_outer, conductor_height)) in primer
  Box1_1 = Box1.duplicate_along_line(step=(r_inner-r_inner_middle, 0mm, 0mm), total=2) in primer
  middle_inner_cylinder_Split1_1 = middle_inner_cylinder_Split1.copy()
  Box1.subtract(middle_inner_cylinder_Split1_1)
  outer_cylinder_Split1_1 = outer_cylinder_Split1.copy()
  Box1.subtract(outer_cylinder_Split1_1)
  Box1_Separate1, Box1_Separate2 = Box1.separate_bodies()
  Box1.delete()
  outer_cylinder_Split1.unite(middle_inner_cylinder_Split1, Box1_Separate1, Box1_Separate2)
  outer_cylinder_2 = outer_cylinder.copy()
  Box1_1.subtract(outer_cylinder_2)
  middle_inner_cylinder_2 = middle_inner_cylinder.copy()
  Box1_1.subtract(middle_inner_cylinder_2)
  Box1_1_Separate1, Box1_1_Separate2 = Box1_1.separate_bodies()
  Box1_1.delete()
  outer_cylinder.unite(Box1_1_Separate2, middle_inner_cylinder, Box1_1_Separate1)
  Box2 = box(corner=(0mm, -r_outer, 0mm), size=(r_inner_middle-r_inner, 2*r_outer, conductor_height)) in seconder
  Box3 = box(corner=(0mm, -r_outer, 0mm), size=(r_inner-r_inner_middle, 2*r_outer, conductor_height)) in seconder
  Box4 = box(corner=(-r_outer, 0mm, 0mm), size=(2*r_outer, r_inner_middle-r_inner, conductor_height)) in seconder
  Box5 = box(corner=(-r_outer, 0mm, 0mm), size=(2*r_outer, r_inner-r_inner_middle, conductor_height)) in seconder
  outer_cylinder_1_1 = outer_cylinder_1.copy()
  Box3.subtract(outer_cylinder_1_1)
  middle_inner_cylinder_1_1 = middle_inner_cylinder_1.copy()
  middle_inner_cylinder_1_Split2_1 = middle_inner_cylinder_1_Split2.copy()
  outer_cylinder_1_2 = outer_cylinder_1.copy()
  outer_cylinder_1_Split2_1 = outer_cylinder_1_Split2.copy()
  Box3.subtract(middle_inner_cylinder_1_1, middle_inner_cylinder_1_Split2_1, outer_cylinder_1_2, outer_cylinder_1_Split2_1)
  middle_inner_cylinder_1_Split1_1 = middle_inner_cylinder_1_Split1.copy()
  middle_inner_cylinder_1_Split1_Split1_1 = middle_inner_cylinder_1_Split1_Split1.copy()
  outer_cylinder_1_Split1_1 = outer_cylinder_1_Split1.copy()
  outer_cylinder_1_Split1_Split1_1 = outer_cylinder_1_Split1_Split1.copy()
  Box2.subtract(middle_inner_cylinder_1_Split1_1, middle_inner_cylinder_1_Split1_Split1_1, outer_cylinder_1_Split1_1, outer_cylinder_1_Split1_Split1_1)
  middle_inner_cylinder_1_Split1_2 = middle_inner_cylinder_1_Split1.copy()
  middle_inner_cylinder_1_Split1_Split1_2 = middle_inner_cylinder_1_Split1_Split1.copy()
  outer_cylinder_1_Split1_2 = outer_cylinder_1_Split1.copy()
  outer_cylinder_1_Split1_Split1_2 = outer_cylinder_1_Split1_Split1.copy()
  Box5.subtract(middle_inner_cylinder_1_Split1_2, middle_inner_cylinder_1_Split1_Split1_2, outer_cylinder_1_Split1_2, outer_cylinder_1_Split1_Split1_2)
  middle_inner_cylinder_1_Split1_Split1_3 = middle_inner_cylinder_1_Split1_Split1.copy()
  middle_inner_cylinder_1_Split2_2 = middle_inner_cylinder_1_Split2.copy()
  outer_cylinder_1_Split1_Split1_3 = outer_cylinder_1_Split1_Split1.copy()
  outer_cylinder_1_Split2_2 = outer_cylinder_1_Split2.copy()
  Box4.subtract(middle_inner_cylinder_1_Split1_Split1_3, middle_inner_cylinder_1_Split2_2, outer_cylinder_1_Split1_Split1_3, outer_cylinder_1_Split2_2)
  Box4_Separate1, Box4_Separate3 = Box4.separate_bodies()
  Box4.delete()
  Box5_Separate1, Box5_Separate2 = Box5.separate_bodies()
  Box5.delete()
  Box2_Separate1, Box2_Separate4 = Box2.separate_bodies()
  Box2.delete()
  Box3_Separate1 [copper], Box3_Separate3 = Box3.separate_bodies()
  Box3.delete()
  middle_inner_cylinder_1_2 = middle_inner_cylinder_1.copy()
  outer_cylinder_1_3 = outer_cylinder_1.copy()
  Box5_Separate2.subtract(middle_inner_cylinder_1_2, outer_cylinder_1_3)
  Box5_Separate2_Separate1 = Box5_Separate2.separate_bodies()
  Box5_Separate2.delete()
  Box3_Separate1.unite(middle_inner_cylinder_1, outer_cylinder_1, Box5_Separate2_Separate1)
  outer_cylinder_1_Split1.unite(Box2_Separate4, middle_inner_cylinder_1_Split1, Box5_Separate1)
  outer_cylinder_1_Split2.unite(Box4_Separate3, middle_inner_cylinder_1_Split2, Box3_Separate3)
  middle_inner_cylinder_1_Split1_Split1.unite(Box4_Separate1, Box2_Separate1, outer_cylinder_1_Split1_Split1)
  outer_cylinder_Section1 [copper] = outer_cylinder.section(plane=ZX) in primer
  outer_cylinder_Split1_Section1 [copper] = outer_cylinder_Split1.section(plane=ZX) in primer
  outer_cylinder_Section1.separate_bodies()
  outer_cylinder_Split1_Section1.separate_bodies()
  coordinate_system RelativeCS3 = origin=(0mm, r_inner-r_inner_middle-5mm, 0mm) x=(1mm, 0mm, 0mm) y=(0mm, 1mm, 0mm) in seconder
  outer_cylinder_1_Split2_Section1 [copper] = outer_cylinder_1_Split2.section(plane=ZX) in RelativeCS2
  middle_inner_cylinder_1_Split1_Split1_Section1 = middle_inner_cylinder_1_Split1_Split1.section(plane=ZX) in RelativeCS2
  middle_inner_cylinder_1_Split1_Split1_Section1_Separate1 [copper] = middle_inner_cylinder_1_Split1_Split1_Section1.separate_bodies()
  middle_inner_cylinder_1_Split1_Split1_Section1.delete()
  outer_cylinder_1_Split2_Section1.separate_bodies()
  outer_cylinder_1_Split1_Section1 [copper] = outer_cylinder_1_Split1.section(plane=ZX) in RelativeCS3
  Box3_Separate1_Section1 = Box3_Separate1.section(plane=ZX) in RelativeCS3
  outer_cylinder_1_Split1_Section1.separate_bodies()
  Box3_Separate1_Section1_Separate1 [copper] = Box3_Separate1_Section1.separate_bodies()
  Box3_Separate1_Section1.delete()
  Region [vacuum] = region(percentage_offset=200 on all sides) in RelativeCS3
  outer_cylinder_1_Split2.rotate(axis=Z, angle=angle_rotation) in seconder
  Box3_Separate1_Section1_Separate1.rotate(axis=Z, angle=angle_rotation) in seconder
  [Box3_Separate1, outer_cylinder_1_Split1, middle_inner_cylinder_1_Split1_Split1, outer_cylinder_1_Split2_Section1, middle_inner_cylinder_1_Split1_Split1_Section1_Separate1, outer_cylinder_1_Split1_Section1, Box3_Separate1_Section1_Separate1].rotate(axis=Z, angle=angle_rotation) in seconder
boundaries and excitations:
  insulating: Insulating Objects=[outer_cylinder, outer_cylinder_1_Split1, outer_cylinder_Split1, outer_cylinder_1_Split2, middle_inner_cylinder_1_Split1_Split1, Box3_Separate1]
  Current_1: Current Objects=outer_cylinder_1_Split1_Section1 Current=1A IsSolid=false Point_out_of_terminal=false
  Current_2: Current Objects=Box3_Separate1_Section1_Separate1 Current=1A IsSolid=false Point_out_of_terminal=true
  Current_3: Current Objects=middle_inner_cylinder_1_Split1_Split1_Section1_Separate1 Current=1A IsSolid=false Point_out_of_terminal=false
  Current_4: Current Objects=outer_cylinder_1_Split2_Section1 Current=1A IsSolid=false Point_out_of_terminal=true
  Current_5: Current Objects=outer_cylinder_Split1_Section1 Current=1A IsSolid=false Point_out_of_terminal=false
  Current_6: Current Objects=outer_cylinder_Section1 Current=1A IsSolid=false Point_out_of_terminal=true
parameters:
  Matrix1: Matrix Current_1..Current_6: NumberOfTurns=20
mesh:
  initial mesh: GlobalCurvilinear{Apply}
setups:
  Setup1: Magnetostatic MaximumPasses=10 MinimumPasses=2 MinimumConvergedPasses=1 PercentRefinement=30 PercentError=1 NonLinearResidual=0.001
optimetrics:
  ParametricSetup1: Parametric Sim._Setups=[Setup1]
    sweep angle_rotation: LIN 0deg 90deg 30deg
    calculate Matrix1.CplCoef(Current_2,Current_1) on Setup1 : LastAdaptive
    calculate Matrix1.CplCoef(Current_3,Current_1) on Setup1 : LastAdaptive
    calculate Matrix1.CplCoef(Current_4,Current_1) on Setup1 : LastAdaptive
    calculate Matrix1.CplCoef(Current_5,Current_1) on Setup1 : LastAdaptive
    calculate Matrix1.CplCoef(Current_6,Current_1) on Setup1 : LastAdaptive
    calculate Matrix1.CplCoef(Current_1,Current_2) on Setup1 : LastAdaptive
    calculate Matrix1.CplCoef(Current_3,Current_2) on Setup1 : LastAdaptive
    calculate Matrix1.CplCoef(Current_4,Current_2) on Setup1 : LastAdaptive
    calculate Matrix1.CplCoef(Current_5,Current_2) on Setup1 : LastAdaptive
    calculate Matrix1.CplCoef(Current_6,Current_2) on Setup1 : LastAdaptive
    calculate Matrix1.CplCoef(Current_1,Current_3) on Setup1 : LastAdaptive
    calculate Matrix1.CplCoef(Current_2,Current_3) on Setup1 : LastAdaptive
    calculate Matrix1.CplCoef(Current_4,Current_3) on Setup1 : LastAdaptive
    calculate Matrix1.CplCoef(Current_5,Current_3) on Setup1 : LastAdaptive
    calculate Matrix1.CplCoef(Current_6,Current_3) on Setup1 : LastAdaptive
    calculate Matrix1.CplCoef(Current_1,Current_4) on Setup1 : LastAdaptive
    calculate Matrix1.CplCoef(Current_2,Current_4) on Setup1 : LastAdaptive
    calculate Matrix1.CplCoef(Current_3,Current_4) on Setup1 : LastAdaptive
    calculate Matrix1.CplCoef(Current_5,Current_4) on Setup1 : LastAdaptive
    calculate Matrix1.CplCoef(Current_1,Current_5) on Setup1 : LastAdaptive
    calculate Matrix1.CplCoef(Current_2,Current_5) on Setup1 : LastAdaptive
    calculate Matrix1.CplCoef(Current_3,Current_5) on Setup1 : LastAdaptive
    calculate Matrix1.CplCoef(Current_4,Current_5) on Setup1 : LastAdaptive
    calculate Matrix1.CplCoef(Current_6,Current_5) on Setup1 : LastAdaptive
    calculate Matrix1.CplCoef(Current_1,Current_6) on Setup1 : LastAdaptive
    calculate Matrix1.CplCoef(Current_2,Current_6) on Setup1 : LastAdaptive
    calculate Matrix1.CplCoef(Current_3,Current_6) on Setup1 : LastAdaptive
    calculate Matrix1.CplCoef(Current_4,Current_6) on Setup1 : LastAdaptive
    calculate Matrix1.CplCoef(Current_5,Current_6) on Setup1 : LastAdaptive
